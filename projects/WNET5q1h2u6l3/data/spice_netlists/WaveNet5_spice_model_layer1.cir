* 状态变量滤波器电路 - NGspice Simulation
* 滤波器数量: 2
* SVF 1: 截止频率: 10 Hz, Q因子: 1.0
* SVF 2: 截止频率: 80 Hz, Q因子: 1.0

* Power Supply
Vcc vcc 0 8.0
Vee vee 0 -8.0

* 输入电压源（将被PWL数据替换）
Vin1 in 0 AC 1.

* SVF 1 电路实现 (输出: out1=高通, out2=带通, out3=低通)
* 参数: 截止频率=10Hz, Q=1.0
* 输入和反馈电阻
R1 N001 in 10000.0
R2 out3 N001 10000.0
R3 out1 N001 10000.0
R4 N002 out1 10000.0
R5 N003 out2 10000.0
C1 out2 N002 1.5915494309189535e-06
C2 out3 N003 1.5915494309189535e-06
R6 out2 N005 20000.0
R7 N005 0 10000.0

* 运放电路 - 高通、带通和低通输出

* 高通滤波器运放

* 理想运放模型
* 使用高增益比较反相端和同相端的电压差
EU1 out1 0 N005 N001 1000000000.0
* 添加极高阻抗的输入电阻以模拟理想运放
Rin_XU1 N001 N005 1000000000000.0
* 添加极小的输出电阻以增强驱动能力
Rout_XU1 out1 0 1e-06

* 带通滤波器运放

* 理想运放模型
* 使用高增益比较反相端和同相端的电压差
EU2 out2 0 0 N002 1000000000.0
* 添加极高阻抗的输入电阻以模拟理想运放
Rin_XU2 N002 0 1000000000000.0
* 添加极小的输出电阻以增强驱动能力
Rout_XU2 out2 0 1e-06

* 低通滤波器运放

* 理想运放模型
* 使用高增益比较反相端和同相端的电压差
EU3 out3 0 0 N003 1000000000.0
* 添加极高阻抗的输入电阻以模拟理想运放
Rin_XU3 N003 0 1000000000000.0
* 添加极小的输出电阻以增强驱动能力
Rout_XU3 out3 0 1e-06

* SVF 2 电路实现 (输出: out4=高通, out5=带通, out6=低通)
* 参数: 截止频率=80Hz, Q=1.0
* 输入和反馈电阻
R11 N011 in 10000.0
R12 out6 N011 10000.0
R13 out4 N011 10000.0
R14 N012 out4 10000.0
R15 N013 out5 10000.0
C11 out5 N012 1.989436788648692e-07
C12 out6 N013 1.989436788648692e-07
R16 out5 N015 20000.0
R17 N015 0 10000.0

* 运放电路 - 高通、带通和低通输出

* 高通滤波器运放

* 理想运放模型
* 使用高增益比较反相端和同相端的电压差
EU4 out4 0 N015 N011 1000000000.0
* 添加极高阻抗的输入电阻以模拟理想运放
Rin_XU4 N011 N015 1000000000000.0
* 添加极小的输出电阻以增强驱动能力
Rout_XU4 out4 0 1e-06

* 带通滤波器运放

* 理想运放模型
* 使用高增益比较反相端和同相端的电压差
EU5 out5 0 0 N012 1000000000.0
* 添加极高阻抗的输入电阻以模拟理想运放
Rin_XU5 N012 0 1000000000000.0
* 添加极小的输出电阻以增强驱动能力
Rout_XU5 out5 0 1e-06

* 低通滤波器运放

* 理想运放模型
* 使用高增益比较反相端和同相端的电压差
EU6 out6 0 0 N013 1000000000.0
* 添加极高阻抗的输入电阻以模拟理想运放
Rin_XU6 N013 0 1000000000000.0
* 添加极小的输出电阻以增强驱动能力
Rout_XU6 out6 0 1e-06
