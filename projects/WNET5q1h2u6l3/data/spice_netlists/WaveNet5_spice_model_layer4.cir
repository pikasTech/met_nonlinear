* Differential Current-Sampling Signed Adder Circuit - NGspice Simulation
* 基于差分电流采样的带符号加法器电路
* 输入数量: 6
* 输出通道数: 6
* 增益矩阵形状: (6, 6)
* 偏置功能: 启用
* ReLU激活: 启用
* 偏置值: [-0.05491336062550545, -0.0002541987632866949, -0.07502543926239014, -0.10622888803482056, -0.380825936794281, -0.05633459612727165]

* 二极管模型 (用于ReLU激活)
 .model 1N4148 D(Is=2.52n Rs=0.568 N=1.752 Cjo=4p M=0.4 tt=20n)
* .model 1N4148 D(Is=1e-14 N=1 Rs=0 Cjo=0 tt=0)

* Power Supply
Vcc vcc 0 8.0
Vee vee 0 -8.0

* Define input voltage sources (will be replaced with PWL data)
Vin1 in1 0 0
Vin2 in2 0 0
Vin3 in3 0 0
Vin4 in4 0 0
Vin5 in5 0 0
Vin6 in6 0 0

* 输出通道 1 - 差分电流采样的带符号加法器电路
* 通道 1 的增益列表: [-0.30477598309516907, -0.4978518486022949, -0.023943912237882614, -0.09576745331287384, -0.757131814956665, -0.5386748313903809]
* 通道 1 的偏置值: -0.05491336062550545
R_pos1_1 in1 curr_pos1 1000000000.0
R_neg1_1 in1 curr_neg1 3281.098431196729
R_pos1_2 in2 curr_pos1 1000000000.0
R_neg1_2 in2 curr_neg1 2008.6296813147765
R_pos1_3 in3 curr_pos1 1000000000.0
R_neg1_3 in3 curr_neg1 41764.26935017997
R_pos1_4 in4 curr_pos1 1000000000.0
R_neg1_4 in4 curr_neg1 10441.960868824439
R_pos1_5 in5 curr_pos1 1000000000.0
R_neg1_5 in5 curr_neg1 1320.773979174598
R_pos1_6 in6 curr_pos1 1000000000.0
R_neg1_6 in6 curr_neg1 1856.4075054683483
R_bias_pos1 vcc curr_pos1 1000000000.0
R_bias_neg1 vcc curr_neg1 145684.03588623682
Rin_pos1 curr_pos1 0 1.0
Rin_neg1 curr_neg1 0 1.0
R1_pos1 curr_pos1 pos1 499.5004995004995
R1_neg1 curr_neg1 neg1 499.5004995004995
R2_neg1 neg1 out1_pre 500000.0
R2_pos1 pos1 0 500000.0

* 理想运放模型
* 使用高增益比较反相端和同相端的电压差
Eopamp1 out1_pre 0 pos1 neg1 1000000000.0
* 添加极高阻抗的输入电阻以模拟理想运放
Rin_Xopamp1 neg1 pos1 1000000000000.0
* 添加极小的输出电阻以增强驱动能力
Rout_Xopamp1 out1_pre 0 1e-06

* 通道 1 的ReLU激活电路 (运放实现)

* 输入电阻
Rin_relu1 out1_pre inv_relu1 10000.0

* 反馈电阻 (增益为1.0)
Rfb_relu1 out1 inv_relu1 10000.0

* 二极管D1: 运放输出到反相端
D1_relu1 op_out_relu1 inv_relu1 1N4148

* 二极管D2: 输出端到运放输出
D2_relu1 out1 op_out_relu1 1N4148

* 理想运放模型
* 使用高增益比较反相端和同相端的电压差
Eopamp_relu1 op_out_relu1 0 0 inv_relu1 1000000000.0
* 添加极高阻抗的输入电阻以模拟理想运放
Rin_Xopamp_relu1 inv_relu1 0 1000000000000.0
* 添加极小的输出电阻以增强驱动能力
Rout_Xopamp_relu1 op_out_relu1 0 1e-06

* 输出通道 2 - 差分电流采样的带符号加法器电路
* 通道 2 的增益列表: [0.09303917735815048, 0.7343928217887878, 0.6351817846298218, 0.17987269163131714, 1.0989803075790405, 0.3012928366661072]
* 通道 2 的偏置值: -0.0002541987632866949
R_pos2_1 in1 curr_pos2 10748.160381411599
R_neg2_1 in1 curr_neg2 1000000000.0
R_pos2_2 in2 curr_pos2 1361.669082718242
R_neg2_2 in2 curr_neg2 1000000000.0
R_pos2_3 in3 curr_pos2 1574.3524518461923
R_neg2_3 in3 curr_neg2 1000000000.0
R_pos2_4 in4 curr_pos2 5559.487607211036
R_neg2_4 in4 curr_neg2 1000000000.0
R_pos2_5 in5 curr_pos2 909.9344120213713
R_neg2_5 in5 curr_neg2 1000000000.0
R_pos2_6 in6 curr_pos2 3319.030120547474
R_neg2_6 in6 curr_neg2 1000000000.0
R_bias_pos2 vcc curr_pos2 1000000000.0
R_bias_neg2 vcc curr_neg2 31471435.567046013
Rin_pos2 curr_pos2 0 1.0
Rin_neg2 curr_neg2 0 1.0
R1_pos2 curr_pos2 pos2 499.5004995004995
R1_neg2 curr_neg2 neg2 499.5004995004995
R2_neg2 neg2 out2_pre 500000.0
R2_pos2 pos2 0 500000.0

* 理想运放模型
* 使用高增益比较反相端和同相端的电压差
Eopamp2 out2_pre 0 pos2 neg2 1000000000.0
* 添加极高阻抗的输入电阻以模拟理想运放
Rin_Xopamp2 neg2 pos2 1000000000000.0
* 添加极小的输出电阻以增强驱动能力
Rout_Xopamp2 out2_pre 0 1e-06

* 通道 2 的ReLU激活电路 (运放实现)

* 输入电阻
Rin_relu2 out2_pre inv_relu2 10000.0

* 反馈电阻 (增益为1.0)
Rfb_relu2 out2 inv_relu2 10000.0

* 二极管D1: 运放输出到反相端
D1_relu2 op_out_relu2 inv_relu2 1N4148

* 二极管D2: 输出端到运放输出
D2_relu2 out2 op_out_relu2 1N4148

* 理想运放模型
* 使用高增益比较反相端和同相端的电压差
Eopamp_relu2 op_out_relu2 0 0 inv_relu2 1000000000.0
* 添加极高阻抗的输入电阻以模拟理想运放
Rin_Xopamp_relu2 inv_relu2 0 1000000000000.0
* 添加极小的输出电阻以增强驱动能力
Rout_Xopamp_relu2 op_out_relu2 0 1e-06

* 输出通道 3 - 差分电流采样的带符号加法器电路
* 通道 3 的增益列表: [0.025074617937207222, 0.17271888256072998, -0.19248676300048828, -0.3263184726238251, -0.7197156548500061, -0.4764655828475952]
* 通道 3 的偏置值: -0.07502543926239014
R_pos3_1 in1 curr_pos3 39880.96658159405
R_neg3_1 in1 curr_neg3 1000000000.0
R_pos3_2 in2 curr_pos3 5789.754919520095
R_neg3_2 in2 curr_neg3 1000000000.0
R_pos3_3 in3 curr_pos3 1000000000.0
R_neg3_3 in3 curr_neg3 5195.162433052414
R_pos3_4 in4 curr_pos3 1000000000.0
R_neg3_4 in4 curr_neg3 3064.490931081259
R_pos3_5 in5 curr_pos3 1000000000.0
R_neg3_5 in5 curr_neg3 1389.4376108970523
R_pos3_6 in6 curr_pos3 1000000000.0
R_neg3_6 in6 curr_neg3 2098.787480143902
R_bias_pos3 vcc curr_pos3 1000000000.0
R_bias_neg3 vcc curr_neg3 106630.49865021395
Rin_pos3 curr_pos3 0 1.0
Rin_neg3 curr_neg3 0 1.0
R1_pos3 curr_pos3 pos3 499.5004995004995
R1_neg3 curr_neg3 neg3 499.5004995004995
R2_neg3 neg3 out3_pre 500000.0
R2_pos3 pos3 0 500000.0

* 理想运放模型
* 使用高增益比较反相端和同相端的电压差
Eopamp3 out3_pre 0 pos3 neg3 1000000000.0
* 添加极高阻抗的输入电阻以模拟理想运放
Rin_Xopamp3 neg3 pos3 1000000000000.0
* 添加极小的输出电阻以增强驱动能力
Rout_Xopamp3 out3_pre 0 1e-06

* 通道 3 的ReLU激活电路 (运放实现)

* 输入电阻
Rin_relu3 out3_pre inv_relu3 10000.0

* 反馈电阻 (增益为1.0)
Rfb_relu3 out3 inv_relu3 10000.0

* 二极管D1: 运放输出到反相端
D1_relu3 op_out_relu3 inv_relu3 1N4148

* 二极管D2: 输出端到运放输出
D2_relu3 out3 op_out_relu3 1N4148

* 理想运放模型
* 使用高增益比较反相端和同相端的电压差
Eopamp_relu3 op_out_relu3 0 0 inv_relu3 1000000000.0
* 添加极高阻抗的输入电阻以模拟理想运放
Rin_Xopamp_relu3 inv_relu3 0 1000000000000.0
* 添加极小的输出电阻以增强驱动能力
Rout_Xopamp_relu3 op_out_relu3 0 1e-06

* 输出通道 4 - 差分电流采样的带符号加法器电路
* 通道 4 的增益列表: [0.027451643720269203, 0.7272149920463562, -1.9065356254577637, -0.44762906432151794, -0.9198263883590698, 0.2847959101200104]
* 通道 4 的偏置值: -0.10622888803482056
R_pos4_1 in1 curr_pos4 36427.69118636199
R_neg4_1 in1 curr_neg4 1000000000.0
R_pos4_2 in2 curr_pos4 1375.1091643284703
R_neg4_2 in2 curr_neg4 1000000000.0
R_pos4_3 in3 curr_pos4 1000000000.0
R_neg4_3 in3 curr_neg4 524.511573058016
R_pos4_4 in4 curr_pos4 1000000000.0
R_neg4_4 in4 curr_neg4 2233.9925614877666
R_pos4_5 in5 curr_pos4 1000000000.0
R_neg4_5 in5 curr_neg4 1087.1616781770704
R_pos4_6 in6 curr_pos4 3511.2863790024553
R_neg4_6 in6 curr_neg4 1000000000.0
R_bias_pos4 vcc curr_pos4 1000000000.0
R_bias_neg4 vcc curr_neg4 75309.08162549623
Rin_pos4 curr_pos4 0 1.0
Rin_neg4 curr_neg4 0 1.0
R1_pos4 curr_pos4 pos4 499.5004995004995
R1_neg4 curr_neg4 neg4 499.5004995004995
R2_neg4 neg4 out4_pre 500000.0
R2_pos4 pos4 0 500000.0

* 理想运放模型
* 使用高增益比较反相端和同相端的电压差
Eopamp4 out4_pre 0 pos4 neg4 1000000000.0
* 添加极高阻抗的输入电阻以模拟理想运放
Rin_Xopamp4 neg4 pos4 1000000000000.0
* 添加极小的输出电阻以增强驱动能力
Rout_Xopamp4 out4_pre 0 1e-06

* 通道 4 的ReLU激活电路 (运放实现)

* 输入电阻
Rin_relu4 out4_pre inv_relu4 10000.0

* 反馈电阻 (增益为1.0)
Rfb_relu4 out4 inv_relu4 10000.0

* 二极管D1: 运放输出到反相端
D1_relu4 op_out_relu4 inv_relu4 1N4148

* 二极管D2: 输出端到运放输出
D2_relu4 out4 op_out_relu4 1N4148

* 理想运放模型
* 使用高增益比较反相端和同相端的电压差
Eopamp_relu4 op_out_relu4 0 0 inv_relu4 1000000000.0
* 添加极高阻抗的输入电阻以模拟理想运放
Rin_Xopamp_relu4 inv_relu4 0 1000000000000.0
* 添加极小的输出电阻以增强驱动能力
Rout_Xopamp_relu4 op_out_relu4 0 1e-06

* 输出通道 5 - 差分电流采样的带符号加法器电路
* 通道 5 的增益列表: [-1.991396427154541, 1.492144227027893, 0.24980786442756653, 1.3596433401107788, 0.4387574791908264, 0.26007166504859924]
* 通道 5 的偏置值: -0.380825936794281
R_pos5_1 in1 curr_pos5 1000000000.0
R_neg5_1 in1 curr_neg5 502.1601858696092
R_pos5_2 in2 curr_pos5 670.1765029723945
R_neg5_2 in2 curr_neg5 1000000000.0
R_pos5_3 in3 curr_pos5 4003.0765336051168
R_neg5_3 in3 curr_neg5 1000000000.0
R_pos5_4 in4 curr_pos5 735.4869990526513
R_neg5_4 in4 curr_neg5 1000000000.0
R_pos5_5 in5 curr_pos5 2279.1634272405768
R_neg5_5 in5 curr_neg5 1000000000.0
R_pos5_6 in6 curr_pos5 3845.0940044280924
R_neg5_6 in6 curr_neg5 1000000000.0
R_bias_pos5 vcc curr_pos5 1000000000.0
R_bias_neg5 vcc curr_neg5 21006.97254851508
Rin_pos5 curr_pos5 0 1.0
Rin_neg5 curr_neg5 0 1.0
R1_pos5 curr_pos5 pos5 499.5004995004995
R1_neg5 curr_neg5 neg5 499.5004995004995
R2_neg5 neg5 out5_pre 500000.0
R2_pos5 pos5 0 500000.0

* 理想运放模型
* 使用高增益比较反相端和同相端的电压差
Eopamp5 out5_pre 0 pos5 neg5 1000000000.0
* 添加极高阻抗的输入电阻以模拟理想运放
Rin_Xopamp5 neg5 pos5 1000000000000.0
* 添加极小的输出电阻以增强驱动能力
Rout_Xopamp5 out5_pre 0 1e-06

* 通道 5 的ReLU激活电路 (运放实现)

* 输入电阻
Rin_relu5 out5_pre inv_relu5 10000.0

* 反馈电阻 (增益为1.0)
Rfb_relu5 out5 inv_relu5 10000.0

* 二极管D1: 运放输出到反相端
D1_relu5 op_out_relu5 inv_relu5 1N4148

* 二极管D2: 输出端到运放输出
D2_relu5 out5 op_out_relu5 1N4148

* 理想运放模型
* 使用高增益比较反相端和同相端的电压差
Eopamp_relu5 op_out_relu5 0 0 inv_relu5 1000000000.0
* 添加极高阻抗的输入电阻以模拟理想运放
Rin_Xopamp_relu5 inv_relu5 0 1000000000000.0
* 添加极小的输出电阻以增强驱动能力
Rout_Xopamp_relu5 op_out_relu5 0 1e-06

* 输出通道 6 - 差分电流采样的带符号加法器电路
* 通道 6 的增益列表: [0.05497857183218002, 2.334984064102173, -0.25890734791755676, 0.1996082067489624, 0.9291661977767944, -0.39764001965522766]
* 通道 6 的偏置值: -0.05633459612727165
R_pos6_1 in1 curr_pos6 18188.904634563107
R_neg6_1 in1 curr_neg6 1000000000.0
R_pos6_2 in2 curr_pos6 428.2684474699021
R_neg6_2 in2 curr_neg6 1000000000.0
R_pos6_3 in3 curr_pos6 1000000000.0
R_neg6_3 in3 curr_neg6 3862.3855523730736
R_pos6_4 in4 curr_pos6 5009.8140566818065
R_neg6_4 in4 curr_neg6 1000000000.0
R_pos6_5 in5 curr_pos6 1076.2337269615368
R_neg6_5 in5 curr_neg6 1000000000.0
R_pos6_6 in6 curr_pos6 1000000000.0
R_neg6_6 in6 curr_neg6 2514.837417187149
R_bias_pos6 vcc curr_pos6 1000000000.0
R_bias_neg6 vcc curr_neg6 142008.6509882191
Rin_pos6 curr_pos6 0 1.0
Rin_neg6 curr_neg6 0 1.0
R1_pos6 curr_pos6 pos6 499.5004995004995
R1_neg6 curr_neg6 neg6 499.5004995004995
R2_neg6 neg6 out6_pre 500000.0
R2_pos6 pos6 0 500000.0

* 理想运放模型
* 使用高增益比较反相端和同相端的电压差
Eopamp6 out6_pre 0 pos6 neg6 1000000000.0
* 添加极高阻抗的输入电阻以模拟理想运放
Rin_Xopamp6 neg6 pos6 1000000000000.0
* 添加极小的输出电阻以增强驱动能力
Rout_Xopamp6 out6_pre 0 1e-06

* 通道 6 的ReLU激活电路 (运放实现)

* 输入电阻
Rin_relu6 out6_pre inv_relu6 10000.0

* 反馈电阻 (增益为1.0)
Rfb_relu6 out6 inv_relu6 10000.0

* 二极管D1: 运放输出到反相端
D1_relu6 op_out_relu6 inv_relu6 1N4148

* 二极管D2: 输出端到运放输出
D2_relu6 out6 op_out_relu6 1N4148

* 理想运放模型
* 使用高增益比较反相端和同相端的电压差
Eopamp_relu6 op_out_relu6 0 0 inv_relu6 1000000000.0
* 添加极高阻抗的输入电阻以模拟理想运放
Rin_Xopamp_relu6 inv_relu6 0 1000000000000.0
* 添加极小的输出电阻以增强驱动能力
Rout_Xopamp_relu6 op_out_relu6 0 1e-06
